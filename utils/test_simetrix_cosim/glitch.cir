* D2A change mid-ramp: V(nin) must stay continuous
V_d2a nin 0 PWL FILE "code:libcosim_bridge.so:nvc_bridge_init:d2a:nin"
R1 nin nout 1k
C1 nout 0 100p
.tran 10p 200n
.print tran V(nin) V(nout)
.end
